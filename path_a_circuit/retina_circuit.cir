* Path A -- retina equivalent circuit (spatial grid + RC + integrate-and-fire)
* Auto-generated by 04_path_a_ngspice_circuit.py -- see that file's docstring
* for what each stage models and why these particular values were chosen.

* Dummy first element -- empirically required. This ngspice build silently
* fails to evaluate the transient waveform of whatever element is listed
* FIRST in the netlist (verified directly: an identical source works fine
* in second position but stays frozen at its t=0 value in first position,
* and this fix -- an unrelated placeholder element first -- resolves it).
* Also: PWL FILE=<path> (external file) breaks with more than one such
* source in the same netlist (verified directly too), so every pixel's
* stimulus is embedded as inline PWL(...) breakpoints instead.
Rdummy dummy0 0 1Meg

Vpix_1_3 photo_1_3 0 PWL(0.000000e+00 0.0000 8.333333e-03 0.0000 1.666667e-02 0.5000 2.500000e-02 0.5000 3.333333e-02 -0.5000 4.166667e-02 -0.5000 5.000000e-02 0.5000 5.833333e-02 -0.5000 6.666667e-02 -0.5000 7.500000e-02 -0.5000 8.333333e-02 -0.5000 9.166667e-02 0.5000 1.000000e-01 -0.5000 1.083333e-01 0.5000 1.166667e-01 0.5000 1.250000e-01 0.5000 1.333333e-01 -0.5000 1.416667e-01 0.5000 1.500000e-01 -0.5000 1.583333e-01 0.5000 1.666667e-01 0.5000 1.750000e-01 0.5000 1.833333e-01 0.5000 1.916667e-01 0.5000 2.000000e-01 0.5000 2.083333e-01 0.5000 2.166667e-01 -0.5000 2.250000e-01 0.5000 2.333333e-01 -0.5000 2.416667e-01 -0.5000 2.500000e-01 -0.5000 2.583333e-01 -0.5000 2.666667e-01 0.5000 2.750000e-01 0.5000 2.833333e-01 -0.5000 2.916667e-01 0.5000 3.000000e-01 -0.5000 3.083333e-01 0.5000 3.166667e-01 0.5000 3.250000e-01 0.5000 3.333333e-01 -0.5000 3.416667e-01 -0.5000 3.500000e-01 -0.5000 3.583333e-01 0.5000 3.666667e-01 -0.5000 3.750000e-01 -0.5000 3.833333e-01 -0.5000 3.916667e-01 0.5000 4.000000e-01 0.5000 4.083333e-01 -0.5000 4.166667e-01 -0.5000 4.250000e-01 0.5000 4.333333e-01 -0.5000 4.416667e-01 0.5000 4.500000e-01 0.5000 4.583333e-01 -0.5000 4.666667e-01 0.5000 4.750000e-01 -0.5000 4.833333e-01 -0.5000 4.916667e-01 -0.5000 5.000000e-01 -0.5000 5.083333e-01 -0.5000 5.166667e-01 -0.5000 5.250000e-01 -0.5000 5.333333e-01 -0.5000 5.416667e-01 -0.5000 5.500000e-01 -0.5000 5.583333e-01 -0.5000 5.666667e-01 -0.5000 5.750000e-01 0.5000 5.833333e-01 -0.5000 5.916667e-01 0.5000 6.000000e-01 0.5000 6.083333e-01 0.5000 6.166667e-01 0.5000 6.250000e-01 -0.5000 6.333333e-01 -0.5000 6.416667e-01 0.5000 6.500000e-01 -0.5000 6.583333e-01 0.5000 6.666667e-01 0.5000 6.750000e-01 0.5000 6.833333e-01 -0.5000 6.916667e-01 -0.5000 7.000000e-01 0.5000 7.083333e-01 -0.5000 7.166667e-01 0.5000 7.250000e-01 -0.5000 7.333333e-01 -0.5000 7.416667e-01 0.5000 7.500000e-01 -0.5000 7.583333e-01 -0.5000 7.666667e-01 -0.5000 7.750000e-01 0.5000 7.833333e-01 -0.5000 7.916667e-01 0.5000 8.000000e-01 -0.5000 8.083333e-01 0.5000 8.166667e-01 0.5000 8.250000e-01 0.5000)
Vpix_1_4 photo_1_4 0 PWL(0.000000e+00 0.0000 8.333333e-03 0.0000 1.666667e-02 -0.5000 2.500000e-02 0.5000 3.333333e-02 0.5000 4.166667e-02 0.5000 5.000000e-02 -0.5000 5.833333e-02 0.5000 6.666667e-02 0.5000 7.500000e-02 -0.5000 8.333333e-02 -0.5000 9.166667e-02 0.5000 1.000000e-01 -0.5000 1.083333e-01 0.5000 1.166667e-01 0.5000 1.250000e-01 0.5000 1.333333e-01 -0.5000 1.416667e-01 -0.5000 1.500000e-01 -0.5000 1.583333e-01 -0.5000 1.666667e-01 0.5000 1.750000e-01 0.5000 1.833333e-01 0.5000 1.916667e-01 0.5000 2.000000e-01 -0.5000 2.083333e-01 0.5000 2.166667e-01 -0.5000 2.250000e-01 -0.5000 2.333333e-01 -0.5000 2.416667e-01 -0.5000 2.500000e-01 -0.5000 2.583333e-01 0.5000 2.666667e-01 0.5000 2.750000e-01 -0.5000 2.833333e-01 -0.5000 2.916667e-01 0.5000 3.000000e-01 -0.5000 3.083333e-01 0.5000 3.166667e-01 0.5000 3.250000e-01 -0.5000 3.333333e-01 0.5000 3.416667e-01 0.5000 3.500000e-01 -0.5000 3.583333e-01 -0.5000 3.666667e-01 0.5000 3.750000e-01 0.5000 3.833333e-01 -0.5000 3.916667e-01 -0.5000 4.000000e-01 -0.5000 4.083333e-01 -0.5000 4.166667e-01 -0.5000 4.250000e-01 0.5000 4.333333e-01 0.5000 4.416667e-01 0.5000 4.500000e-01 0.5000 4.583333e-01 0.5000 4.666667e-01 -0.5000 4.750000e-01 -0.5000 4.833333e-01 -0.5000 4.916667e-01 0.5000 5.000000e-01 -0.5000 5.083333e-01 -0.5000 5.166667e-01 0.5000 5.250000e-01 -0.5000 5.333333e-01 0.5000 5.416667e-01 -0.5000 5.500000e-01 -0.5000 5.583333e-01 0.5000 5.666667e-01 -0.5000 5.750000e-01 0.5000 5.833333e-01 0.5000 5.916667e-01 0.5000 6.000000e-01 -0.5000 6.083333e-01 0.5000 6.166667e-01 -0.5000 6.250000e-01 0.5000 6.333333e-01 -0.5000 6.416667e-01 -0.5000 6.500000e-01 0.5000 6.583333e-01 0.5000 6.666667e-01 0.5000 6.750000e-01 0.5000 6.833333e-01 -0.5000 6.916667e-01 -0.5000 7.000000e-01 -0.5000 7.083333e-01 -0.5000 7.166667e-01 0.5000 7.250000e-01 0.5000 7.333333e-01 0.5000 7.416667e-01 -0.5000 7.500000e-01 0.5000 7.583333e-01 0.5000 7.666667e-01 0.5000 7.750000e-01 -0.5000 7.833333e-01 -0.5000 7.916667e-01 0.5000 8.000000e-01 -0.5000 8.083333e-01 -0.5000 8.166667e-01 -0.5000 8.250000e-01 0.5000)
Vpix_1_5 photo_1_5 0 PWL(0.000000e+00 0.0000 8.333333e-03 0.0000 1.666667e-02 -0.5000 2.500000e-02 0.5000 3.333333e-02 -0.5000 4.166667e-02 -0.5000 5.000000e-02 0.5000 5.833333e-02 -0.5000 6.666667e-02 0.5000 7.500000e-02 -0.5000 8.333333e-02 -0.5000 9.166667e-02 -0.5000 1.000000e-01 -0.5000 1.083333e-01 0.5000 1.166667e-01 0.5000 1.250000e-01 -0.5000 1.333333e-01 0.5000 1.416667e-01 0.5000 1.500000e-01 0.5000 1.583333e-01 -0.5000 1.666667e-01 -0.5000 1.750000e-01 0.5000 1.833333e-01 0.5000 1.916667e-01 -0.5000 2.000000e-01 0.5000 2.083333e-01 -0.5000 2.166667e-01 -0.5000 2.250000e-01 0.5000 2.333333e-01 0.5000 2.416667e-01 0.5000 2.500000e-01 0.5000 2.583333e-01 0.5000 2.666667e-01 -0.5000 2.750000e-01 0.5000 2.833333e-01 0.5000 2.916667e-01 -0.5000 3.000000e-01 0.5000 3.083333e-01 -0.5000 3.166667e-01 -0.5000 3.250000e-01 0.5000 3.333333e-01 -0.5000 3.416667e-01 0.5000 3.500000e-01 0.5000 3.583333e-01 -0.5000 3.666667e-01 0.5000 3.750000e-01 -0.5000 3.833333e-01 0.5000 3.916667e-01 -0.5000 4.000000e-01 -0.5000 4.083333e-01 0.5000 4.166667e-01 0.5000 4.250000e-01 -0.5000 4.333333e-01 -0.5000 4.416667e-01 0.5000 4.500000e-01 -0.5000 4.583333e-01 -0.5000 4.666667e-01 0.5000 4.750000e-01 -0.5000 4.833333e-01 0.5000 4.916667e-01 0.5000 5.000000e-01 0.5000 5.083333e-01 -0.5000 5.166667e-01 -0.5000 5.250000e-01 -0.5000 5.333333e-01 -0.5000 5.416667e-01 0.5000 5.500000e-01 -0.5000 5.583333e-01 0.5000 5.666667e-01 0.5000 5.750000e-01 0.5000 5.833333e-01 -0.5000 5.916667e-01 0.5000 6.000000e-01 0.5000 6.083333e-01 -0.5000 6.166667e-01 -0.5000 6.250000e-01 0.5000 6.333333e-01 -0.5000 6.416667e-01 -0.5000 6.500000e-01 -0.5000 6.583333e-01 0.5000 6.666667e-01 -0.5000 6.750000e-01 0.5000 6.833333e-01 0.5000 6.916667e-01 0.5000 7.000000e-01 -0.5000 7.083333e-01 0.5000 7.166667e-01 0.5000 7.250000e-01 -0.5000 7.333333e-01 -0.5000 7.416667e-01 0.5000 7.500000e-01 -0.5000 7.583333e-01 -0.5000 7.666667e-01 -0.5000 7.750000e-01 0.5000 7.833333e-01 -0.5000 7.916667e-01 -0.5000 8.000000e-01 0.5000 8.083333e-01 0.5000 8.166667e-01 0.5000 8.250000e-01 0.5000)
Vpix_1_6 photo_1_6 0 PWL(0.000000e+00 0.0000 8.333333e-03 0.0000 1.666667e-02 -0.5000 2.500000e-02 -0.5000 3.333333e-02 0.5000 4.166667e-02 -0.5000 5.000000e-02 0.5000 5.833333e-02 0.5000 6.666667e-02 -0.5000 7.500000e-02 -0.5000 8.333333e-02 0.5000 9.166667e-02 0.5000 1.000000e-01 -0.5000 1.083333e-01 0.5000 1.166667e-01 0.5000 1.250000e-01 -0.5000 1.333333e-01 0.5000 1.416667e-01 0.5000 1.500000e-01 -0.5000 1.583333e-01 -0.5000 1.666667e-01 0.5000 1.750000e-01 -0.5000 1.833333e-01 0.5000 1.916667e-01 0.5000 2.000000e-01 0.5000 2.083333e-01 -0.5000 2.166667e-01 -0.5000 2.250000e-01 0.5000 2.333333e-01 -0.5000 2.416667e-01 -0.5000 2.500000e-01 0.5000 2.583333e-01 -0.5000 2.666667e-01 0.5000 2.750000e-01 -0.5000 2.833333e-01 0.5000 2.916667e-01 -0.5000 3.000000e-01 0.5000 3.083333e-01 -0.5000 3.166667e-01 -0.5000 3.250000e-01 0.5000 3.333333e-01 0.5000 3.416667e-01 -0.5000 3.500000e-01 0.5000 3.583333e-01 -0.5000 3.666667e-01 0.5000 3.750000e-01 0.5000 3.833333e-01 0.5000 3.916667e-01 -0.5000 4.000000e-01 0.5000 4.083333e-01 -0.5000 4.166667e-01 -0.5000 4.250000e-01 -0.5000 4.333333e-01 0.5000 4.416667e-01 0.5000 4.500000e-01 -0.5000 4.583333e-01 0.5000 4.666667e-01 0.5000 4.750000e-01 -0.5000 4.833333e-01 0.5000 4.916667e-01 -0.5000 5.000000e-01 0.5000 5.083333e-01 -0.5000 5.166667e-01 0.5000 5.250000e-01 -0.5000 5.333333e-01 -0.5000 5.416667e-01 -0.5000 5.500000e-01 -0.5000 5.583333e-01 -0.5000 5.666667e-01 0.5000 5.750000e-01 -0.5000 5.833333e-01 0.5000 5.916667e-01 -0.5000 6.000000e-01 0.5000 6.083333e-01 0.5000 6.166667e-01 -0.5000 6.250000e-01 -0.5000 6.333333e-01 -0.5000 6.416667e-01 0.5000 6.500000e-01 -0.5000 6.583333e-01 -0.5000 6.666667e-01 -0.5000 6.750000e-01 -0.5000 6.833333e-01 -0.5000 6.916667e-01 -0.5000 7.000000e-01 -0.5000 7.083333e-01 0.5000 7.166667e-01 -0.5000 7.250000e-01 -0.5000 7.333333e-01 0.5000 7.416667e-01 -0.5000 7.500000e-01 0.5000 7.583333e-01 -0.5000 7.666667e-01 0.5000 7.750000e-01 0.5000 7.833333e-01 -0.5000 7.916667e-01 -0.5000 8.000000e-01 0.5000 8.083333e-01 0.5000 8.166667e-01 -0.5000 8.250000e-01 0.5000)
Vpix_1_7 photo_1_7 0 PWL(0.000000e+00 0.0000 8.333333e-03 0.0000 1.666667e-02 0.5000 2.500000e-02 0.5000 3.333333e-02 0.5000 4.166667e-02 -0.5000 5.000000e-02 -0.5000 5.833333e-02 -0.5000 6.666667e-02 -0.5000 7.500000e-02 0.5000 8.333333e-02 -0.5000 9.166667e-02 0.5000 1.000000e-01 0.5000 1.083333e-01 -0.5000 1.166667e-01 0.5000 1.250000e-01 0.5000 1.333333e-01 -0.5000 1.416667e-01 -0.5000 1.500000e-01 -0.5000 1.583333e-01 0.5000 1.666667e-01 0.5000 1.750000e-01 0.5000 1.833333e-01 0.5000 1.916667e-01 -0.5000 2.000000e-01 -0.5000 2.083333e-01 -0.5000 2.166667e-01 0.5000 2.250000e-01 -0.5000 2.333333e-01 0.5000 2.416667e-01 0.5000 2.500000e-01 -0.5000 2.583333e-01 -0.5000 2.666667e-01 0.5000 2.750000e-01 0.5000 2.833333e-01 0.5000 2.916667e-01 -0.5000 3.000000e-01 0.5000 3.083333e-01 -0.5000 3.166667e-01 0.5000 3.250000e-01 -0.5000 3.333333e-01 0.5000 3.416667e-01 0.5000 3.500000e-01 0.5000 3.583333e-01 0.5000 3.666667e-01 0.5000 3.750000e-01 0.5000 3.833333e-01 -0.5000 3.916667e-01 -0.5000 4.000000e-01 0.5000 4.083333e-01 -0.5000 4.166667e-01 -0.5000 4.250000e-01 -0.5000 4.333333e-01 0.5000 4.416667e-01 -0.5000 4.500000e-01 0.5000 4.583333e-01 0.5000 4.666667e-01 -0.5000 4.750000e-01 -0.5000 4.833333e-01 -0.5000 4.916667e-01 -0.5000 5.000000e-01 -0.5000 5.083333e-01 0.5000 5.166667e-01 -0.5000 5.250000e-01 -0.5000 5.333333e-01 -0.5000 5.416667e-01 -0.5000 5.500000e-01 -0.5000 5.583333e-01 -0.5000 5.666667e-01 -0.5000 5.750000e-01 0.5000 5.833333e-01 -0.5000 5.916667e-01 -0.5000 6.000000e-01 0.5000 6.083333e-01 -0.5000 6.166667e-01 -0.5000 6.250000e-01 -0.5000 6.333333e-01 -0.5000 6.416667e-01 -0.5000 6.500000e-01 -0.5000 6.583333e-01 0.5000 6.666667e-01 -0.5000 6.750000e-01 0.5000 6.833333e-01 0.5000 6.916667e-01 -0.5000 7.000000e-01 -0.5000 7.083333e-01 -0.5000 7.166667e-01 -0.5000 7.250000e-01 -0.5000 7.333333e-01 0.5000 7.416667e-01 0.5000 7.500000e-01 -0.5000 7.583333e-01 -0.5000 7.666667e-01 -0.5000 7.750000e-01 -0.5000 7.833333e-01 -0.5000 7.916667e-01 0.5000 8.000000e-01 0.5000 8.083333e-01 0.5000 8.166667e-01 -0.5000 8.250000e-01 0.5000)
Vpix_2_3 photo_2_3 0 PWL(0.000000e+00 0.0000 8.333333e-03 0.0000 1.666667e-02 -0.5000 2.500000e-02 0.5000 3.333333e-02 0.5000 4.166667e-02 0.5000 5.000000e-02 0.5000 5.833333e-02 -0.5000 6.666667e-02 -0.5000 7.500000e-02 0.5000 8.333333e-02 0.5000 9.166667e-02 -0.5000 1.000000e-01 0.5000 1.083333e-01 0.5000 1.166667e-01 -0.5000 1.250000e-01 -0.5000 1.333333e-01 -0.5000 1.416667e-01 0.5000 1.500000e-01 0.5000 1.583333e-01 0.5000 1.666667e-01 0.5000 1.750000e-01 -0.5000 1.833333e-01 0.5000 1.916667e-01 0.5000 2.000000e-01 0.5000 2.083333e-01 0.5000 2.166667e-01 0.5000 2.250000e-01 -0.5000 2.333333e-01 0.5000 2.416667e-01 -0.5000 2.500000e-01 -0.5000 2.583333e-01 0.5000 2.666667e-01 -0.5000 2.750000e-01 -0.5000 2.833333e-01 -0.5000 2.916667e-01 0.5000 3.000000e-01 -0.5000 3.083333e-01 0.5000 3.166667e-01 -0.5000 3.250000e-01 0.5000 3.333333e-01 0.5000 3.416667e-01 0.5000 3.500000e-01 -0.5000 3.583333e-01 0.5000 3.666667e-01 0.5000 3.750000e-01 -0.5000 3.833333e-01 0.5000 3.916667e-01 -0.5000 4.000000e-01 -0.5000 4.083333e-01 0.5000 4.166667e-01 -0.5000 4.250000e-01 -0.5000 4.333333e-01 0.5000 4.416667e-01 0.5000 4.500000e-01 -0.5000 4.583333e-01 -0.5000 4.666667e-01 -0.5000 4.750000e-01 -0.5000 4.833333e-01 0.5000 4.916667e-01 -0.5000 5.000000e-01 -0.5000 5.083333e-01 -0.5000 5.166667e-01 -0.5000 5.250000e-01 0.5000 5.333333e-01 -0.5000 5.416667e-01 -0.5000 5.500000e-01 0.5000 5.583333e-01 0.5000 5.666667e-01 -0.5000 5.750000e-01 0.5000 5.833333e-01 -0.5000 5.916667e-01 0.5000 6.000000e-01 0.5000 6.083333e-01 -0.5000 6.166667e-01 0.5000 6.250000e-01 -0.5000 6.333333e-01 0.5000 6.416667e-01 0.5000 6.500000e-01 -0.5000 6.583333e-01 0.5000 6.666667e-01 0.5000 6.750000e-01 0.5000 6.833333e-01 0.5000 6.916667e-01 -0.5000 7.000000e-01 -0.5000 7.083333e-01 -0.5000 7.166667e-01 0.5000 7.250000e-01 0.5000 7.333333e-01 -0.5000 7.416667e-01 -0.5000 7.500000e-01 -0.5000 7.583333e-01 -0.5000 7.666667e-01 -0.5000 7.750000e-01 0.5000 7.833333e-01 -0.5000 7.916667e-01 0.5000 8.000000e-01 -0.5000 8.083333e-01 0.5000 8.166667e-01 0.5000 8.250000e-01 0.5000)
Vpix_2_4 photo_2_4 0 PWL(0.000000e+00 0.0000 8.333333e-03 0.0000 1.666667e-02 -0.5000 2.500000e-02 -0.5000 3.333333e-02 0.5000 4.166667e-02 0.5000 5.000000e-02 0.5000 5.833333e-02 0.5000 6.666667e-02 0.5000 7.500000e-02 0.5000 8.333333e-02 -0.5000 9.166667e-02 0.5000 1.000000e-01 0.5000 1.083333e-01 0.5000 1.166667e-01 -0.5000 1.250000e-01 0.5000 1.333333e-01 0.5000 1.416667e-01 0.5000 1.500000e-01 -0.5000 1.583333e-01 -0.5000 1.666667e-01 -0.5000 1.750000e-01 -0.5000 1.833333e-01 0.5000 1.916667e-01 0.5000 2.000000e-01 -0.5000 2.083333e-01 -0.5000 2.166667e-01 -0.5000 2.250000e-01 -0.5000 2.333333e-01 -0.5000 2.416667e-01 0.5000 2.500000e-01 0.5000 2.583333e-01 -0.5000 2.666667e-01 -0.5000 2.750000e-01 0.5000 2.833333e-01 -0.5000 2.916667e-01 -0.5000 3.000000e-01 -0.5000 3.083333e-01 -0.5000 3.166667e-01 0.5000 3.250000e-01 -0.5000 3.333333e-01 0.5000 3.416667e-01 0.5000 3.500000e-01 0.5000 3.583333e-01 -0.5000 3.666667e-01 -0.5000 3.750000e-01 0.5000 3.833333e-01 -0.5000 3.916667e-01 -0.5000 4.000000e-01 0.5000 4.083333e-01 -0.5000 4.166667e-01 -0.5000 4.250000e-01 0.5000 4.333333e-01 -0.5000 4.416667e-01 0.5000 4.500000e-01 0.5000 4.583333e-01 0.5000 4.666667e-01 -0.5000 4.750000e-01 -0.5000 4.833333e-01 0.5000 4.916667e-01 -0.5000 5.000000e-01 -0.5000 5.083333e-01 -0.5000 5.166667e-01 0.5000 5.250000e-01 -0.5000 5.333333e-01 0.5000 5.416667e-01 0.5000 5.500000e-01 -0.5000 5.583333e-01 0.5000 5.666667e-01 -0.5000 5.750000e-01 0.5000 5.833333e-01 -0.5000 5.916667e-01 0.5000 6.000000e-01 -0.5000 6.083333e-01 0.5000 6.166667e-01 0.5000 6.250000e-01 0.5000 6.333333e-01 0.5000 6.416667e-01 0.5000 6.500000e-01 -0.5000 6.583333e-01 0.5000 6.666667e-01 0.5000 6.750000e-01 0.5000 6.833333e-01 -0.5000 6.916667e-01 0.5000 7.000000e-01 0.5000 7.083333e-01 -0.5000 7.166667e-01 0.5000 7.250000e-01 -0.5000 7.333333e-01 0.5000 7.416667e-01 -0.5000 7.500000e-01 -0.5000 7.583333e-01 -0.5000 7.666667e-01 -0.5000 7.750000e-01 -0.5000 7.833333e-01 0.5000 7.916667e-01 -0.5000 8.000000e-01 0.5000 8.083333e-01 0.5000 8.166667e-01 -0.5000 8.250000e-01 0.5000)
Vpix_2_5 photo_2_5 0 PWL(0.000000e+00 0.0000 8.333333e-03 0.0000 1.666667e-02 -0.5000 2.500000e-02 0.5000 3.333333e-02 0.5000 4.166667e-02 -0.5000 5.000000e-02 0.5000 5.833333e-02 0.5000 6.666667e-02 0.5000 7.500000e-02 -0.5000 8.333333e-02 -0.5000 9.166667e-02 0.5000 1.000000e-01 -0.5000 1.083333e-01 -0.5000 1.166667e-01 0.5000 1.250000e-01 -0.5000 1.333333e-01 -0.5000 1.416667e-01 0.5000 1.500000e-01 0.5000 1.583333e-01 0.5000 1.666667e-01 0.5000 1.750000e-01 0.5000 1.833333e-01 -0.5000 1.916667e-01 0.5000 2.000000e-01 0.5000 2.083333e-01 -0.5000 2.166667e-01 0.5000 2.250000e-01 0.5000 2.333333e-01 -0.5000 2.416667e-01 -0.5000 2.500000e-01 -0.5000 2.583333e-01 -0.5000 2.666667e-01 -0.5000 2.750000e-01 0.5000 2.833333e-01 0.5000 2.916667e-01 -0.5000 3.000000e-01 0.5000 3.083333e-01 0.5000 3.166667e-01 -0.5000 3.250000e-01 -0.5000 3.333333e-01 -0.5000 3.416667e-01 0.5000 3.500000e-01 -0.5000 3.583333e-01 0.5000 3.666667e-01 0.5000 3.750000e-01 0.5000 3.833333e-01 -0.5000 3.916667e-01 -0.5000 4.000000e-01 -0.5000 4.083333e-01 0.5000 4.166667e-01 0.5000 4.250000e-01 0.5000 4.333333e-01 -0.5000 4.416667e-01 -0.5000 4.500000e-01 -0.5000 4.583333e-01 -0.5000 4.666667e-01 0.5000 4.750000e-01 -0.5000 4.833333e-01 0.5000 4.916667e-01 -0.5000 5.000000e-01 -0.5000 5.083333e-01 -0.5000 5.166667e-01 -0.5000 5.250000e-01 -0.5000 5.333333e-01 -0.5000 5.416667e-01 0.5000 5.500000e-01 0.5000 5.583333e-01 -0.5000 5.666667e-01 0.5000 5.750000e-01 0.5000 5.833333e-01 0.5000 5.916667e-01 -0.5000 6.000000e-01 -0.5000 6.083333e-01 0.5000 6.166667e-01 -0.5000 6.250000e-01 0.5000 6.333333e-01 0.5000 6.416667e-01 -0.5000 6.500000e-01 -0.5000 6.583333e-01 0.5000 6.666667e-01 0.5000 6.750000e-01 -0.5000 6.833333e-01 -0.5000 6.916667e-01 -0.5000 7.000000e-01 0.5000 7.083333e-01 -0.5000 7.166667e-01 -0.5000 7.250000e-01 -0.5000 7.333333e-01 -0.5000 7.416667e-01 0.5000 7.500000e-01 -0.5000 7.583333e-01 0.5000 7.666667e-01 -0.5000 7.750000e-01 0.5000 7.833333e-01 0.5000 7.916667e-01 0.5000 8.000000e-01 0.5000 8.083333e-01 0.5000 8.166667e-01 0.5000 8.250000e-01 -0.5000)
Vpix_2_6 photo_2_6 0 PWL(0.000000e+00 0.0000 8.333333e-03 0.0000 1.666667e-02 -0.5000 2.500000e-02 0.5000 3.333333e-02 0.5000 4.166667e-02 -0.5000 5.000000e-02 0.5000 5.833333e-02 -0.5000 6.666667e-02 -0.5000 7.500000e-02 -0.5000 8.333333e-02 0.5000 9.166667e-02 0.5000 1.000000e-01 -0.5000 1.083333e-01 0.5000 1.166667e-01 -0.5000 1.250000e-01 -0.5000 1.333333e-01 -0.5000 1.416667e-01 -0.5000 1.500000e-01 -0.5000 1.583333e-01 0.5000 1.666667e-01 -0.5000 1.750000e-01 -0.5000 1.833333e-01 0.5000 1.916667e-01 -0.5000 2.000000e-01 -0.5000 2.083333e-01 0.5000 2.166667e-01 -0.5000 2.250000e-01 0.5000 2.333333e-01 0.5000 2.416667e-01 -0.5000 2.500000e-01 -0.5000 2.583333e-01 0.5000 2.666667e-01 0.5000 2.750000e-01 0.5000 2.833333e-01 0.5000 2.916667e-01 -0.5000 3.000000e-01 0.5000 3.083333e-01 -0.5000 3.166667e-01 0.5000 3.250000e-01 0.5000 3.333333e-01 0.5000 3.416667e-01 -0.5000 3.500000e-01 -0.5000 3.583333e-01 -0.5000 3.666667e-01 0.5000 3.750000e-01 -0.5000 3.833333e-01 0.5000 3.916667e-01 0.5000 4.000000e-01 -0.5000 4.083333e-01 -0.5000 4.166667e-01 0.5000 4.250000e-01 0.5000 4.333333e-01 -0.5000 4.416667e-01 0.5000 4.500000e-01 0.5000 4.583333e-01 -0.5000 4.666667e-01 0.5000 4.750000e-01 0.5000 4.833333e-01 0.5000 4.916667e-01 -0.5000 5.000000e-01 -0.5000 5.083333e-01 0.5000 5.166667e-01 0.5000 5.250000e-01 0.5000 5.333333e-01 -0.5000 5.416667e-01 0.5000 5.500000e-01 -0.5000 5.583333e-01 0.5000 5.666667e-01 0.5000 5.750000e-01 -0.5000 5.833333e-01 -0.5000 5.916667e-01 -0.5000 6.000000e-01 -0.5000 6.083333e-01 0.5000 6.166667e-01 0.5000 6.250000e-01 -0.5000 6.333333e-01 -0.5000 6.416667e-01 0.5000 6.500000e-01 0.5000 6.583333e-01 0.5000 6.666667e-01 -0.5000 6.750000e-01 0.5000 6.833333e-01 0.5000 6.916667e-01 -0.5000 7.000000e-01 -0.5000 7.083333e-01 0.5000 7.166667e-01 0.5000 7.250000e-01 -0.5000 7.333333e-01 -0.5000 7.416667e-01 0.5000 7.500000e-01 0.5000 7.583333e-01 0.5000 7.666667e-01 0.5000 7.750000e-01 -0.5000 7.833333e-01 -0.5000 7.916667e-01 0.5000 8.000000e-01 0.5000 8.083333e-01 0.5000 8.166667e-01 -0.5000 8.250000e-01 0.5000)
Vpix_2_7 photo_2_7 0 PWL(0.000000e+00 0.0000 8.333333e-03 0.0000 1.666667e-02 -0.5000 2.500000e-02 -0.5000 3.333333e-02 0.5000 4.166667e-02 0.5000 5.000000e-02 -0.5000 5.833333e-02 -0.5000 6.666667e-02 -0.5000 7.500000e-02 0.5000 8.333333e-02 -0.5000 9.166667e-02 0.5000 1.000000e-01 0.5000 1.083333e-01 -0.5000 1.166667e-01 0.5000 1.250000e-01 -0.5000 1.333333e-01 0.5000 1.416667e-01 0.5000 1.500000e-01 0.5000 1.583333e-01 0.5000 1.666667e-01 0.5000 1.750000e-01 -0.5000 1.833333e-01 -0.5000 1.916667e-01 -0.5000 2.000000e-01 0.5000 2.083333e-01 -0.5000 2.166667e-01 -0.5000 2.250000e-01 -0.5000 2.333333e-01 -0.5000 2.416667e-01 0.5000 2.500000e-01 0.5000 2.583333e-01 -0.5000 2.666667e-01 0.5000 2.750000e-01 0.5000 2.833333e-01 0.5000 2.916667e-01 0.5000 3.000000e-01 -0.5000 3.083333e-01 0.5000 3.166667e-01 0.5000 3.250000e-01 0.5000 3.333333e-01 0.5000 3.416667e-01 -0.5000 3.500000e-01 -0.5000 3.583333e-01 -0.5000 3.666667e-01 -0.5000 3.750000e-01 -0.5000 3.833333e-01 -0.5000 3.916667e-01 0.5000 4.000000e-01 0.5000 4.083333e-01 -0.5000 4.166667e-01 -0.5000 4.250000e-01 0.5000 4.333333e-01 -0.5000 4.416667e-01 0.5000 4.500000e-01 0.5000 4.583333e-01 -0.5000 4.666667e-01 0.5000 4.750000e-01 -0.5000 4.833333e-01 0.5000 4.916667e-01 -0.5000 5.000000e-01 0.5000 5.083333e-01 0.5000 5.166667e-01 -0.5000 5.250000e-01 -0.5000 5.333333e-01 0.5000 5.416667e-01 -0.5000 5.500000e-01 -0.5000 5.583333e-01 0.5000 5.666667e-01 0.5000 5.750000e-01 -0.5000 5.833333e-01 -0.5000 5.916667e-01 -0.5000 6.000000e-01 -0.5000 6.083333e-01 0.5000 6.166667e-01 -0.5000 6.250000e-01 -0.5000 6.333333e-01 -0.5000 6.416667e-01 0.5000 6.500000e-01 0.5000 6.583333e-01 -0.5000 6.666667e-01 0.5000 6.750000e-01 0.5000 6.833333e-01 -0.5000 6.916667e-01 -0.5000 7.000000e-01 -0.5000 7.083333e-01 -0.5000 7.166667e-01 -0.5000 7.250000e-01 0.5000 7.333333e-01 -0.5000 7.416667e-01 -0.5000 7.500000e-01 -0.5000 7.583333e-01 -0.5000 7.666667e-01 -0.5000 7.750000e-01 0.5000 7.833333e-01 0.5000 7.916667e-01 -0.5000 8.000000e-01 0.5000 8.083333e-01 -0.5000 8.166667e-01 -0.5000 8.250000e-01 0.5000)
Vpix_3_3 photo_3_3 0 PWL(0.000000e+00 0.0000 8.333333e-03 0.0000 1.666667e-02 0.5000 2.500000e-02 -0.5000 3.333333e-02 0.5000 4.166667e-02 0.5000 5.000000e-02 -0.5000 5.833333e-02 0.5000 6.666667e-02 0.5000 7.500000e-02 0.5000 8.333333e-02 -0.5000 9.166667e-02 -0.5000 1.000000e-01 0.5000 1.083333e-01 -0.5000 1.166667e-01 0.5000 1.250000e-01 -0.5000 1.333333e-01 0.5000 1.416667e-01 -0.5000 1.500000e-01 0.5000 1.583333e-01 0.5000 1.666667e-01 0.5000 1.750000e-01 0.5000 1.833333e-01 -0.5000 1.916667e-01 0.5000 2.000000e-01 0.5000 2.083333e-01 -0.5000 2.166667e-01 -0.5000 2.250000e-01 0.5000 2.333333e-01 -0.5000 2.416667e-01 0.5000 2.500000e-01 -0.5000 2.583333e-01 0.5000 2.666667e-01 0.5000 2.750000e-01 0.5000 2.833333e-01 -0.5000 2.916667e-01 0.5000 3.000000e-01 0.5000 3.083333e-01 -0.5000 3.166667e-01 0.5000 3.250000e-01 -0.5000 3.333333e-01 0.5000 3.416667e-01 0.5000 3.500000e-01 -0.5000 3.583333e-01 0.5000 3.666667e-01 -0.5000 3.750000e-01 -0.5000 3.833333e-01 0.5000 3.916667e-01 0.5000 4.000000e-01 -0.5000 4.083333e-01 0.5000 4.166667e-01 0.5000 4.250000e-01 -0.5000 4.333333e-01 0.5000 4.416667e-01 0.5000 4.500000e-01 0.5000 4.583333e-01 -0.5000 4.666667e-01 -0.5000 4.750000e-01 -0.5000 4.833333e-01 -0.5000 4.916667e-01 -0.5000 5.000000e-01 -0.5000 5.083333e-01 -0.5000 5.166667e-01 0.5000 5.250000e-01 -0.5000 5.333333e-01 0.5000 5.416667e-01 0.5000 5.500000e-01 0.5000 5.583333e-01 0.5000 5.666667e-01 0.5000 5.750000e-01 0.5000 5.833333e-01 -0.5000 5.916667e-01 0.5000 6.000000e-01 0.5000 6.083333e-01 -0.5000 6.166667e-01 0.5000 6.250000e-01 -0.5000 6.333333e-01 0.5000 6.416667e-01 0.5000 6.500000e-01 -0.5000 6.583333e-01 0.5000 6.666667e-01 0.5000 6.750000e-01 -0.5000 6.833333e-01 -0.5000 6.916667e-01 -0.5000 7.000000e-01 -0.5000 7.083333e-01 0.5000 7.166667e-01 -0.5000 7.250000e-01 0.5000 7.333333e-01 -0.5000 7.416667e-01 0.5000 7.500000e-01 0.5000 7.583333e-01 -0.5000 7.666667e-01 0.5000 7.750000e-01 -0.5000 7.833333e-01 0.5000 7.916667e-01 0.5000 8.000000e-01 0.5000 8.083333e-01 0.5000 8.166667e-01 -0.5000 8.250000e-01 -0.5000)
Vpix_3_4 photo_3_4 0 PWL(0.000000e+00 0.0000 8.333333e-03 0.0000 1.666667e-02 -0.5000 2.500000e-02 -0.5000 3.333333e-02 0.5000 4.166667e-02 -0.5000 5.000000e-02 0.5000 5.833333e-02 0.5000 6.666667e-02 0.5000 7.500000e-02 0.5000 8.333333e-02 -0.5000 9.166667e-02 0.5000 1.000000e-01 0.5000 1.083333e-01 0.5000 1.166667e-01 0.5000 1.250000e-01 0.5000 1.333333e-01 0.5000 1.416667e-01 0.5000 1.500000e-01 -0.5000 1.583333e-01 0.5000 1.666667e-01 -0.5000 1.750000e-01 -0.5000 1.833333e-01 -0.5000 1.916667e-01 -0.5000 2.000000e-01 0.5000 2.083333e-01 -0.5000 2.166667e-01 0.5000 2.250000e-01 0.5000 2.333333e-01 0.5000 2.416667e-01 -0.5000 2.500000e-01 0.5000 2.583333e-01 0.5000 2.666667e-01 0.5000 2.750000e-01 -0.5000 2.833333e-01 -0.5000 2.916667e-01 0.5000 3.000000e-01 0.5000 3.083333e-01 0.5000 3.166667e-01 -0.5000 3.250000e-01 -0.5000 3.333333e-01 -0.5000 3.416667e-01 -0.5000 3.500000e-01 -0.5000 3.583333e-01 -0.5000 3.666667e-01 0.5000 3.750000e-01 0.5000 3.833333e-01 -0.5000 3.916667e-01 0.5000 4.000000e-01 -0.5000 4.083333e-01 0.5000 4.166667e-01 -0.5000 4.250000e-01 -0.5000 4.333333e-01 0.5000 4.416667e-01 -0.5000 4.500000e-01 -0.5000 4.583333e-01 0.5000 4.666667e-01 -0.5000 4.750000e-01 0.5000 4.833333e-01 -0.5000 4.916667e-01 0.5000 5.000000e-01 -0.5000 5.083333e-01 -0.5000 5.166667e-01 -0.5000 5.250000e-01 0.5000 5.333333e-01 0.5000 5.416667e-01 0.5000 5.500000e-01 -0.5000 5.583333e-01 0.5000 5.666667e-01 0.5000 5.750000e-01 0.5000 5.833333e-01 0.5000 5.916667e-01 0.5000 6.000000e-01 0.5000 6.083333e-01 -0.5000 6.166667e-01 -0.5000 6.250000e-01 -0.5000 6.333333e-01 -0.5000 6.416667e-01 0.5000 6.500000e-01 -0.5000 6.583333e-01 -0.5000 6.666667e-01 -0.5000 6.750000e-01 0.5000 6.833333e-01 -0.5000 6.916667e-01 0.5000 7.000000e-01 -0.5000 7.083333e-01 0.5000 7.166667e-01 -0.5000 7.250000e-01 0.5000 7.333333e-01 0.5000 7.416667e-01 0.5000 7.500000e-01 -0.5000 7.583333e-01 -0.5000 7.666667e-01 -0.5000 7.750000e-01 0.5000 7.833333e-01 -0.5000 7.916667e-01 0.5000 8.000000e-01 -0.5000 8.083333e-01 -0.5000 8.166667e-01 0.5000 8.250000e-01 -0.5000)
Vpix_3_5 photo_3_5 0 PWL(0.000000e+00 0.0000 8.333333e-03 0.0000 1.666667e-02 -0.5000 2.500000e-02 -0.5000 3.333333e-02 0.5000 4.166667e-02 0.5000 5.000000e-02 -0.5000 5.833333e-02 -0.5000 6.666667e-02 -0.5000 7.500000e-02 0.5000 8.333333e-02 -0.5000 9.166667e-02 -0.5000 1.000000e-01 -0.5000 1.083333e-01 -0.5000 1.166667e-01 -0.5000 1.250000e-01 0.5000 1.333333e-01 -0.5000 1.416667e-01 -0.5000 1.500000e-01 -0.5000 1.583333e-01 0.5000 1.666667e-01 -0.5000 1.750000e-01 0.5000 1.833333e-01 -0.5000 1.916667e-01 -0.5000 2.000000e-01 -0.5000 2.083333e-01 0.5000 2.166667e-01 -0.5000 2.250000e-01 -0.5000 2.333333e-01 -0.5000 2.416667e-01 -0.5000 2.500000e-01 0.5000 2.583333e-01 0.5000 2.666667e-01 -0.5000 2.750000e-01 0.5000 2.833333e-01 -0.5000 2.916667e-01 -0.5000 3.000000e-01 0.5000 3.083333e-01 -0.5000 3.166667e-01 0.5000 3.250000e-01 -0.5000 3.333333e-01 0.5000 3.416667e-01 0.5000 3.500000e-01 0.5000 3.583333e-01 -0.5000 3.666667e-01 -0.5000 3.750000e-01 -0.5000 3.833333e-01 0.5000 3.916667e-01 0.5000 4.000000e-01 0.5000 4.083333e-01 0.5000 4.166667e-01 -0.5000 4.250000e-01 0.5000 4.333333e-01 -0.5000 4.416667e-01 0.5000 4.500000e-01 0.5000 4.583333e-01 -0.5000 4.666667e-01 0.5000 4.750000e-01 0.5000 4.833333e-01 -0.5000 4.916667e-01 0.5000 5.000000e-01 -0.5000 5.083333e-01 0.5000 5.166667e-01 0.5000 5.250000e-01 0.5000 5.333333e-01 0.5000 5.416667e-01 -0.5000 5.500000e-01 0.5000 5.583333e-01 -0.5000 5.666667e-01 0.5000 5.750000e-01 0.5000 5.833333e-01 -0.5000 5.916667e-01 -0.5000 6.000000e-01 -0.5000 6.083333e-01 0.5000 6.166667e-01 -0.5000 6.250000e-01 -0.5000 6.333333e-01 0.5000 6.416667e-01 -0.5000 6.500000e-01 0.5000 6.583333e-01 -0.5000 6.666667e-01 -0.5000 6.750000e-01 0.5000 6.833333e-01 0.5000 6.916667e-01 0.5000 7.000000e-01 0.5000 7.083333e-01 0.5000 7.166667e-01 -0.5000 7.250000e-01 -0.5000 7.333333e-01 0.5000 7.416667e-01 -0.5000 7.500000e-01 0.5000 7.583333e-01 -0.5000 7.666667e-01 0.5000 7.750000e-01 0.5000 7.833333e-01 0.5000 7.916667e-01 -0.5000 8.000000e-01 -0.5000 8.083333e-01 -0.5000 8.166667e-01 0.5000 8.250000e-01 -0.5000)
Vpix_3_6 photo_3_6 0 PWL(0.000000e+00 0.0000 8.333333e-03 0.0000 1.666667e-02 0.5000 2.500000e-02 -0.5000 3.333333e-02 -0.5000 4.166667e-02 -0.5000 5.000000e-02 0.5000 5.833333e-02 0.5000 6.666667e-02 -0.5000 7.500000e-02 0.5000 8.333333e-02 -0.5000 9.166667e-02 0.5000 1.000000e-01 -0.5000 1.083333e-01 0.5000 1.166667e-01 0.5000 1.250000e-01 -0.5000 1.333333e-01 0.5000 1.416667e-01 -0.5000 1.500000e-01 -0.5000 1.583333e-01 -0.5000 1.666667e-01 -0.5000 1.750000e-01 -0.5000 1.833333e-01 0.5000 1.916667e-01 -0.5000 2.000000e-01 -0.5000 2.083333e-01 0.5000 2.166667e-01 -0.5000 2.250000e-01 -0.5000 2.333333e-01 0.5000 2.416667e-01 0.5000 2.500000e-01 0.5000 2.583333e-01 -0.5000 2.666667e-01 0.5000 2.750000e-01 -0.5000 2.833333e-01 -0.5000 2.916667e-01 -0.5000 3.000000e-01 -0.5000 3.083333e-01 -0.5000 3.166667e-01 -0.5000 3.250000e-01 -0.5000 3.333333e-01 0.5000 3.416667e-01 0.5000 3.500000e-01 -0.5000 3.583333e-01 0.5000 3.666667e-01 -0.5000 3.750000e-01 -0.5000 3.833333e-01 0.5000 3.916667e-01 0.5000 4.000000e-01 -0.5000 4.083333e-01 -0.5000 4.166667e-01 0.5000 4.250000e-01 0.5000 4.333333e-01 0.5000 4.416667e-01 0.5000 4.500000e-01 -0.5000 4.583333e-01 0.5000 4.666667e-01 -0.5000 4.750000e-01 0.5000 4.833333e-01 -0.5000 4.916667e-01 0.5000 5.000000e-01 0.5000 5.083333e-01 -0.5000 5.166667e-01 -0.5000 5.250000e-01 -0.5000 5.333333e-01 -0.5000 5.416667e-01 -0.5000 5.500000e-01 -0.5000 5.583333e-01 -0.5000 5.666667e-01 -0.5000 5.750000e-01 0.5000 5.833333e-01 0.5000 5.916667e-01 -0.5000 6.000000e-01 -0.5000 6.083333e-01 0.5000 6.166667e-01 -0.5000 6.250000e-01 0.5000 6.333333e-01 0.5000 6.416667e-01 0.5000 6.500000e-01 -0.5000 6.583333e-01 0.5000 6.666667e-01 0.5000 6.750000e-01 0.5000 6.833333e-01 -0.5000 6.916667e-01 0.5000 7.000000e-01 -0.5000 7.083333e-01 -0.5000 7.166667e-01 -0.5000 7.250000e-01 -0.5000 7.333333e-01 0.5000 7.416667e-01 -0.5000 7.500000e-01 -0.5000 7.583333e-01 -0.5000 7.666667e-01 0.5000 7.750000e-01 0.5000 7.833333e-01 -0.5000 7.916667e-01 -0.5000 8.000000e-01 -0.5000 8.083333e-01 0.5000 8.166667e-01 0.5000 8.250000e-01 0.5000)
Vpix_3_7 photo_3_7 0 PWL(0.000000e+00 0.0000 8.333333e-03 0.0000 1.666667e-02 -0.5000 2.500000e-02 -0.5000 3.333333e-02 -0.5000 4.166667e-02 0.5000 5.000000e-02 -0.5000 5.833333e-02 0.5000 6.666667e-02 -0.5000 7.500000e-02 0.5000 8.333333e-02 -0.5000 9.166667e-02 -0.5000 1.000000e-01 -0.5000 1.083333e-01 -0.5000 1.166667e-01 -0.5000 1.250000e-01 0.5000 1.333333e-01 0.5000 1.416667e-01 0.5000 1.500000e-01 -0.5000 1.583333e-01 0.5000 1.666667e-01 -0.5000 1.750000e-01 -0.5000 1.833333e-01 0.5000 1.916667e-01 0.5000 2.000000e-01 -0.5000 2.083333e-01 0.5000 2.166667e-01 0.5000 2.250000e-01 -0.5000 2.333333e-01 0.5000 2.416667e-01 -0.5000 2.500000e-01 -0.5000 2.583333e-01 0.5000 2.666667e-01 0.5000 2.750000e-01 0.5000 2.833333e-01 -0.5000 2.916667e-01 -0.5000 3.000000e-01 -0.5000 3.083333e-01 -0.5000 3.166667e-01 0.5000 3.250000e-01 0.5000 3.333333e-01 0.5000 3.416667e-01 0.5000 3.500000e-01 0.5000 3.583333e-01 0.5000 3.666667e-01 -0.5000 3.750000e-01 0.5000 3.833333e-01 -0.5000 3.916667e-01 -0.5000 4.000000e-01 -0.5000 4.083333e-01 0.5000 4.166667e-01 -0.5000 4.250000e-01 -0.5000 4.333333e-01 -0.5000 4.416667e-01 -0.5000 4.500000e-01 -0.5000 4.583333e-01 -0.5000 4.666667e-01 0.5000 4.750000e-01 -0.5000 4.833333e-01 0.5000 4.916667e-01 -0.5000 5.000000e-01 -0.5000 5.083333e-01 -0.5000 5.166667e-01 0.5000 5.250000e-01 -0.5000 5.333333e-01 -0.5000 5.416667e-01 -0.5000 5.500000e-01 -0.5000 5.583333e-01 0.5000 5.666667e-01 -0.5000 5.750000e-01 0.5000 5.833333e-01 0.5000 5.916667e-01 0.5000 6.000000e-01 -0.5000 6.083333e-01 -0.5000 6.166667e-01 -0.5000 6.250000e-01 0.5000 6.333333e-01 -0.5000 6.416667e-01 0.5000 6.500000e-01 0.5000 6.583333e-01 -0.5000 6.666667e-01 0.5000 6.750000e-01 0.5000 6.833333e-01 -0.5000 6.916667e-01 0.5000 7.000000e-01 -0.5000 7.083333e-01 0.5000 7.166667e-01 0.5000 7.250000e-01 0.5000 7.333333e-01 0.5000 7.416667e-01 0.5000 7.500000e-01 0.5000 7.583333e-01 -0.5000 7.666667e-01 -0.5000 7.750000e-01 -0.5000 7.833333e-01 -0.5000 7.916667e-01 -0.5000 8.000000e-01 0.5000 8.083333e-01 0.5000 8.166667e-01 0.5000 8.250000e-01 -0.5000)
Vpix_4_3 photo_4_3 0 PWL(0.000000e+00 0.0000 8.333333e-03 0.0000 1.666667e-02 0.5000 2.500000e-02 0.5000 3.333333e-02 0.5000 4.166667e-02 -0.5000 5.000000e-02 -0.5000 5.833333e-02 0.5000 6.666667e-02 -0.5000 7.500000e-02 0.5000 8.333333e-02 0.5000 9.166667e-02 -0.5000 1.000000e-01 0.5000 1.083333e-01 0.5000 1.166667e-01 0.5000 1.250000e-01 -0.5000 1.333333e-01 0.5000 1.416667e-01 0.5000 1.500000e-01 0.5000 1.583333e-01 -0.5000 1.666667e-01 -0.5000 1.750000e-01 -0.5000 1.833333e-01 0.5000 1.916667e-01 -0.5000 2.000000e-01 0.5000 2.083333e-01 0.5000 2.166667e-01 0.5000 2.250000e-01 -0.5000 2.333333e-01 0.5000 2.416667e-01 0.5000 2.500000e-01 -0.5000 2.583333e-01 0.5000 2.666667e-01 -0.5000 2.750000e-01 -0.5000 2.833333e-01 -0.5000 2.916667e-01 0.5000 3.000000e-01 0.5000 3.083333e-01 0.5000 3.166667e-01 0.5000 3.250000e-01 -0.5000 3.333333e-01 0.5000 3.416667e-01 0.5000 3.500000e-01 0.5000 3.583333e-01 -0.5000 3.666667e-01 -0.5000 3.750000e-01 0.5000 3.833333e-01 -0.5000 3.916667e-01 0.5000 4.000000e-01 -0.5000 4.083333e-01 0.5000 4.166667e-01 0.5000 4.250000e-01 -0.5000 4.333333e-01 -0.5000 4.416667e-01 -0.5000 4.500000e-01 -0.5000 4.583333e-01 -0.5000 4.666667e-01 -0.5000 4.750000e-01 0.5000 4.833333e-01 0.5000 4.916667e-01 0.5000 5.000000e-01 0.5000 5.083333e-01 0.5000 5.166667e-01 -0.5000 5.250000e-01 -0.5000 5.333333e-01 0.5000 5.416667e-01 0.5000 5.500000e-01 -0.5000 5.583333e-01 0.5000 5.666667e-01 -0.5000 5.750000e-01 -0.5000 5.833333e-01 -0.5000 5.916667e-01 -0.5000 6.000000e-01 -0.5000 6.083333e-01 0.5000 6.166667e-01 -0.5000 6.250000e-01 -0.5000 6.333333e-01 -0.5000 6.416667e-01 -0.5000 6.500000e-01 -0.5000 6.583333e-01 -0.5000 6.666667e-01 -0.5000 6.750000e-01 -0.5000 6.833333e-01 -0.5000 6.916667e-01 -0.5000 7.000000e-01 0.5000 7.083333e-01 -0.5000 7.166667e-01 -0.5000 7.250000e-01 0.5000 7.333333e-01 -0.5000 7.416667e-01 0.5000 7.500000e-01 -0.5000 7.583333e-01 0.5000 7.666667e-01 -0.5000 7.750000e-01 0.5000 7.833333e-01 -0.5000 7.916667e-01 0.5000 8.000000e-01 0.5000 8.083333e-01 0.5000 8.166667e-01 0.5000 8.250000e-01 -0.5000)
Vpix_4_4 photo_4_4 0 PWL(0.000000e+00 0.0000 8.333333e-03 0.0000 1.666667e-02 0.5000 2.500000e-02 -0.5000 3.333333e-02 -0.5000 4.166667e-02 -0.5000 5.000000e-02 -0.5000 5.833333e-02 -0.5000 6.666667e-02 0.5000 7.500000e-02 -0.5000 8.333333e-02 0.5000 9.166667e-02 -0.5000 1.000000e-01 -0.5000 1.083333e-01 -0.5000 1.166667e-01 -0.5000 1.250000e-01 0.5000 1.333333e-01 -0.5000 1.416667e-01 -0.5000 1.500000e-01 0.5000 1.583333e-01 -0.5000 1.666667e-01 0.5000 1.750000e-01 -0.5000 1.833333e-01 0.5000 1.916667e-01 -0.5000 2.000000e-01 0.5000 2.083333e-01 -0.5000 2.166667e-01 -0.5000 2.250000e-01 -0.5000 2.333333e-01 0.5000 2.416667e-01 0.5000 2.500000e-01 0.5000 2.583333e-01 0.5000 2.666667e-01 -0.5000 2.750000e-01 0.5000 2.833333e-01 0.5000 2.916667e-01 0.5000 3.000000e-01 -0.5000 3.083333e-01 -0.5000 3.166667e-01 -0.5000 3.250000e-01 0.5000 3.333333e-01 0.5000 3.416667e-01 -0.5000 3.500000e-01 0.5000 3.583333e-01 0.5000 3.666667e-01 -0.5000 3.750000e-01 0.5000 3.833333e-01 0.5000 3.916667e-01 -0.5000 4.000000e-01 0.5000 4.083333e-01 -0.5000 4.166667e-01 0.5000 4.250000e-01 0.5000 4.333333e-01 -0.5000 4.416667e-01 0.5000 4.500000e-01 -0.5000 4.583333e-01 -0.5000 4.666667e-01 0.5000 4.750000e-01 0.5000 4.833333e-01 -0.5000 4.916667e-01 0.5000 5.000000e-01 -0.5000 5.083333e-01 0.5000 5.166667e-01 -0.5000 5.250000e-01 0.5000 5.333333e-01 -0.5000 5.416667e-01 -0.5000 5.500000e-01 0.5000 5.583333e-01 0.5000 5.666667e-01 0.5000 5.750000e-01 -0.5000 5.833333e-01 -0.5000 5.916667e-01 0.5000 6.000000e-01 0.5000 6.083333e-01 0.5000 6.166667e-01 0.5000 6.250000e-01 -0.5000 6.333333e-01 -0.5000 6.416667e-01 0.5000 6.500000e-01 0.5000 6.583333e-01 0.5000 6.666667e-01 0.5000 6.750000e-01 0.5000 6.833333e-01 0.5000 6.916667e-01 -0.5000 7.000000e-01 -0.5000 7.083333e-01 0.5000 7.166667e-01 0.5000 7.250000e-01 -0.5000 7.333333e-01 0.5000 7.416667e-01 0.5000 7.500000e-01 0.5000 7.583333e-01 -0.5000 7.666667e-01 0.5000 7.750000e-01 0.5000 7.833333e-01 -0.5000 7.916667e-01 -0.5000 8.000000e-01 -0.5000 8.083333e-01 -0.5000 8.166667e-01 0.5000 8.250000e-01 -0.5000)
Vpix_4_5 photo_4_5 0 PWL(0.000000e+00 0.0000 8.333333e-03 0.0000 1.666667e-02 -0.5000 2.500000e-02 0.5000 3.333333e-02 -0.5000 4.166667e-02 0.5000 5.000000e-02 -0.5000 5.833333e-02 0.5000 6.666667e-02 0.5000 7.500000e-02 0.5000 8.333333e-02 0.5000 9.166667e-02 -0.5000 1.000000e-01 -0.5000 1.083333e-01 0.5000 1.166667e-01 0.5000 1.250000e-01 0.5000 1.333333e-01 0.5000 1.416667e-01 -0.5000 1.500000e-01 0.5000 1.583333e-01 -0.5000 1.666667e-01 -0.5000 1.750000e-01 0.5000 1.833333e-01 0.5000 1.916667e-01 0.5000 2.000000e-01 -0.5000 2.083333e-01 -0.5000 2.166667e-01 0.5000 2.250000e-01 -0.5000 2.333333e-01 0.5000 2.416667e-01 0.5000 2.500000e-01 -0.5000 2.583333e-01 0.5000 2.666667e-01 0.5000 2.750000e-01 -0.5000 2.833333e-01 0.5000 2.916667e-01 -0.5000 3.000000e-01 -0.5000 3.083333e-01 -0.5000 3.166667e-01 -0.5000 3.250000e-01 0.5000 3.333333e-01 -0.5000 3.416667e-01 -0.5000 3.500000e-01 -0.5000 3.583333e-01 0.5000 3.666667e-01 -0.5000 3.750000e-01 -0.5000 3.833333e-01 -0.5000 3.916667e-01 0.5000 4.000000e-01 -0.5000 4.083333e-01 -0.5000 4.166667e-01 -0.5000 4.250000e-01 -0.5000 4.333333e-01 -0.5000 4.416667e-01 -0.5000 4.500000e-01 -0.5000 4.583333e-01 -0.5000 4.666667e-01 0.5000 4.750000e-01 -0.5000 4.833333e-01 -0.5000 4.916667e-01 0.5000 5.000000e-01 0.5000 5.083333e-01 0.5000 5.166667e-01 -0.5000 5.250000e-01 -0.5000 5.333333e-01 -0.5000 5.416667e-01 -0.5000 5.500000e-01 0.5000 5.583333e-01 -0.5000 5.666667e-01 -0.5000 5.750000e-01 -0.5000 5.833333e-01 0.5000 5.916667e-01 0.5000 6.000000e-01 0.5000 6.083333e-01 0.5000 6.166667e-01 0.5000 6.250000e-01 0.5000 6.333333e-01 0.5000 6.416667e-01 0.5000 6.500000e-01 -0.5000 6.583333e-01 -0.5000 6.666667e-01 -0.5000 6.750000e-01 0.5000 6.833333e-01 0.5000 6.916667e-01 -0.5000 7.000000e-01 -0.5000 7.083333e-01 -0.5000 7.166667e-01 0.5000 7.250000e-01 -0.5000 7.333333e-01 -0.5000 7.416667e-01 -0.5000 7.500000e-01 0.5000 7.583333e-01 -0.5000 7.666667e-01 0.5000 7.750000e-01 0.5000 7.833333e-01 0.5000 7.916667e-01 0.5000 8.000000e-01 -0.5000 8.083333e-01 0.5000 8.166667e-01 0.5000 8.250000e-01 -0.5000)
Vpix_4_6 photo_4_6 0 PWL(0.000000e+00 0.0000 8.333333e-03 0.0000 1.666667e-02 0.5000 2.500000e-02 -0.5000 3.333333e-02 -0.5000 4.166667e-02 0.5000 5.000000e-02 0.5000 5.833333e-02 0.5000 6.666667e-02 -0.5000 7.500000e-02 -0.5000 8.333333e-02 -0.5000 9.166667e-02 -0.5000 1.000000e-01 -0.5000 1.083333e-01 0.5000 1.166667e-01 -0.5000 1.250000e-01 -0.5000 1.333333e-01 -0.5000 1.416667e-01 0.5000 1.500000e-01 -0.5000 1.583333e-01 0.5000 1.666667e-01 0.5000 1.750000e-01 0.5000 1.833333e-01 0.5000 1.916667e-01 0.5000 2.000000e-01 -0.5000 2.083333e-01 0.5000 2.166667e-01 -0.5000 2.250000e-01 -0.5000 2.333333e-01 -0.5000 2.416667e-01 0.5000 2.500000e-01 0.5000 2.583333e-01 0.5000 2.666667e-01 0.5000 2.750000e-01 -0.5000 2.833333e-01 0.5000 2.916667e-01 -0.5000 3.000000e-01 -0.5000 3.083333e-01 0.5000 3.166667e-01 0.5000 3.250000e-01 -0.5000 3.333333e-01 0.5000 3.416667e-01 0.5000 3.500000e-01 -0.5000 3.583333e-01 -0.5000 3.666667e-01 0.5000 3.750000e-01 -0.5000 3.833333e-01 0.5000 3.916667e-01 0.5000 4.000000e-01 -0.5000 4.083333e-01 0.5000 4.166667e-01 -0.5000 4.250000e-01 -0.5000 4.333333e-01 -0.5000 4.416667e-01 0.5000 4.500000e-01 0.5000 4.583333e-01 -0.5000 4.666667e-01 0.5000 4.750000e-01 0.5000 4.833333e-01 0.5000 4.916667e-01 -0.5000 5.000000e-01 -0.5000 5.083333e-01 -0.5000 5.166667e-01 -0.5000 5.250000e-01 -0.5000 5.333333e-01 -0.5000 5.416667e-01 -0.5000 5.500000e-01 -0.5000 5.583333e-01 0.5000 5.666667e-01 0.5000 5.750000e-01 -0.5000 5.833333e-01 -0.5000 5.916667e-01 0.5000 6.000000e-01 0.5000 6.083333e-01 0.5000 6.166667e-01 -0.5000 6.250000e-01 0.5000 6.333333e-01 -0.5000 6.416667e-01 -0.5000 6.500000e-01 0.5000 6.583333e-01 -0.5000 6.666667e-01 -0.5000 6.750000e-01 -0.5000 6.833333e-01 0.5000 6.916667e-01 -0.5000 7.000000e-01 -0.5000 7.083333e-01 0.5000 7.166667e-01 0.5000 7.250000e-01 -0.5000 7.333333e-01 0.5000 7.416667e-01 -0.5000 7.500000e-01 -0.5000 7.583333e-01 0.5000 7.666667e-01 -0.5000 7.750000e-01 -0.5000 7.833333e-01 0.5000 7.916667e-01 0.5000 8.000000e-01 -0.5000 8.083333e-01 0.5000 8.166667e-01 -0.5000 8.250000e-01 0.5000)
Vpix_4_7 photo_4_7 0 PWL(0.000000e+00 0.0000 8.333333e-03 0.0000 1.666667e-02 -0.5000 2.500000e-02 -0.5000 3.333333e-02 0.5000 4.166667e-02 -0.5000 5.000000e-02 0.5000 5.833333e-02 -0.5000 6.666667e-02 0.5000 7.500000e-02 -0.5000 8.333333e-02 0.5000 9.166667e-02 0.5000 1.000000e-01 -0.5000 1.083333e-01 0.5000 1.166667e-01 0.5000 1.250000e-01 -0.5000 1.333333e-01 -0.5000 1.416667e-01 0.5000 1.500000e-01 0.5000 1.583333e-01 -0.5000 1.666667e-01 0.5000 1.750000e-01 -0.5000 1.833333e-01 0.5000 1.916667e-01 -0.5000 2.000000e-01 0.5000 2.083333e-01 0.5000 2.166667e-01 0.5000 2.250000e-01 -0.5000 2.333333e-01 0.5000 2.416667e-01 -0.5000 2.500000e-01 0.5000 2.583333e-01 -0.5000 2.666667e-01 0.5000 2.750000e-01 0.5000 2.833333e-01 0.5000 2.916667e-01 0.5000 3.000000e-01 0.5000 3.083333e-01 0.5000 3.166667e-01 0.5000 3.250000e-01 0.5000 3.333333e-01 0.5000 3.416667e-01 -0.5000 3.500000e-01 -0.5000 3.583333e-01 -0.5000 3.666667e-01 0.5000 3.750000e-01 0.5000 3.833333e-01 -0.5000 3.916667e-01 0.5000 4.000000e-01 0.5000 4.083333e-01 0.5000 4.166667e-01 -0.5000 4.250000e-01 0.5000 4.333333e-01 0.5000 4.416667e-01 -0.5000 4.500000e-01 -0.5000 4.583333e-01 -0.5000 4.666667e-01 0.5000 4.750000e-01 -0.5000 4.833333e-01 -0.5000 4.916667e-01 0.5000 5.000000e-01 -0.5000 5.083333e-01 -0.5000 5.166667e-01 -0.5000 5.250000e-01 0.5000 5.333333e-01 -0.5000 5.416667e-01 0.5000 5.500000e-01 -0.5000 5.583333e-01 -0.5000 5.666667e-01 -0.5000 5.750000e-01 -0.5000 5.833333e-01 -0.5000 5.916667e-01 0.5000 6.000000e-01 0.5000 6.083333e-01 -0.5000 6.166667e-01 0.5000 6.250000e-01 0.5000 6.333333e-01 -0.5000 6.416667e-01 0.5000 6.500000e-01 0.5000 6.583333e-01 0.5000 6.666667e-01 0.5000 6.750000e-01 -0.5000 6.833333e-01 -0.5000 6.916667e-01 0.5000 7.000000e-01 -0.5000 7.083333e-01 -0.5000 7.166667e-01 0.5000 7.250000e-01 -0.5000 7.333333e-01 0.5000 7.416667e-01 -0.5000 7.500000e-01 -0.5000 7.583333e-01 0.5000 7.666667e-01 0.5000 7.750000e-01 0.5000 7.833333e-01 -0.5000 7.916667e-01 0.5000 8.000000e-01 0.5000 8.083333e-01 0.5000 8.166667e-01 -0.5000 8.250000e-01 -0.5000)
Vpix_5_3 photo_5_3 0 PWL(0.000000e+00 0.0000 8.333333e-03 0.0000 1.666667e-02 0.5000 2.500000e-02 0.5000 3.333333e-02 0.5000 4.166667e-02 -0.5000 5.000000e-02 -0.5000 5.833333e-02 0.5000 6.666667e-02 0.5000 7.500000e-02 0.5000 8.333333e-02 0.5000 9.166667e-02 -0.5000 1.000000e-01 -0.5000 1.083333e-01 -0.5000 1.166667e-01 0.5000 1.250000e-01 0.5000 1.333333e-01 0.5000 1.416667e-01 -0.5000 1.500000e-01 0.5000 1.583333e-01 0.5000 1.666667e-01 0.5000 1.750000e-01 0.5000 1.833333e-01 0.5000 1.916667e-01 -0.5000 2.000000e-01 0.5000 2.083333e-01 -0.5000 2.166667e-01 -0.5000 2.250000e-01 0.5000 2.333333e-01 0.5000 2.416667e-01 0.5000 2.500000e-01 -0.5000 2.583333e-01 0.5000 2.666667e-01 -0.5000 2.750000e-01 0.5000 2.833333e-01 -0.5000 2.916667e-01 0.5000 3.000000e-01 -0.5000 3.083333e-01 0.5000 3.166667e-01 0.5000 3.250000e-01 -0.5000 3.333333e-01 -0.5000 3.416667e-01 0.5000 3.500000e-01 0.5000 3.583333e-01 0.5000 3.666667e-01 -0.5000 3.750000e-01 -0.5000 3.833333e-01 -0.5000 3.916667e-01 -0.5000 4.000000e-01 -0.5000 4.083333e-01 0.5000 4.166667e-01 -0.5000 4.250000e-01 0.5000 4.333333e-01 0.5000 4.416667e-01 -0.5000 4.500000e-01 0.5000 4.583333e-01 -0.5000 4.666667e-01 -0.5000 4.750000e-01 0.5000 4.833333e-01 -0.5000 4.916667e-01 0.5000 5.000000e-01 -0.5000 5.083333e-01 0.5000 5.166667e-01 -0.5000 5.250000e-01 -0.5000 5.333333e-01 -0.5000 5.416667e-01 0.5000 5.500000e-01 0.5000 5.583333e-01 -0.5000 5.666667e-01 0.5000 5.750000e-01 -0.5000 5.833333e-01 -0.5000 5.916667e-01 -0.5000 6.000000e-01 -0.5000 6.083333e-01 -0.5000 6.166667e-01 0.5000 6.250000e-01 0.5000 6.333333e-01 0.5000 6.416667e-01 0.5000 6.500000e-01 -0.5000 6.583333e-01 -0.5000 6.666667e-01 0.5000 6.750000e-01 0.5000 6.833333e-01 -0.5000 6.916667e-01 0.5000 7.000000e-01 -0.5000 7.083333e-01 0.5000 7.166667e-01 -0.5000 7.250000e-01 -0.5000 7.333333e-01 0.5000 7.416667e-01 0.5000 7.500000e-01 -0.5000 7.583333e-01 -0.5000 7.666667e-01 0.5000 7.750000e-01 0.5000 7.833333e-01 0.5000 7.916667e-01 0.5000 8.000000e-01 -0.5000 8.083333e-01 0.5000 8.166667e-01 0.5000 8.250000e-01 -0.5000)
Vpix_5_4 photo_5_4 0 PWL(0.000000e+00 0.0000 8.333333e-03 0.0000 1.666667e-02 0.5000 2.500000e-02 -0.5000 3.333333e-02 0.5000 4.166667e-02 -0.5000 5.000000e-02 0.5000 5.833333e-02 -0.5000 6.666667e-02 -0.5000 7.500000e-02 0.5000 8.333333e-02 -0.5000 9.166667e-02 0.5000 1.000000e-01 -0.5000 1.083333e-01 -0.5000 1.166667e-01 0.5000 1.250000e-01 0.5000 1.333333e-01 -0.5000 1.416667e-01 0.5000 1.500000e-01 -0.5000 1.583333e-01 -0.5000 1.666667e-01 -0.5000 1.750000e-01 -0.5000 1.833333e-01 -0.5000 1.916667e-01 -0.5000 2.000000e-01 0.5000 2.083333e-01 0.5000 2.166667e-01 -0.5000 2.250000e-01 -0.5000 2.333333e-01 -0.5000 2.416667e-01 0.5000 2.500000e-01 -0.5000 2.583333e-01 0.5000 2.666667e-01 -0.5000 2.750000e-01 0.5000 2.833333e-01 0.5000 2.916667e-01 -0.5000 3.000000e-01 0.5000 3.083333e-01 0.5000 3.166667e-01 0.5000 3.250000e-01 0.5000 3.333333e-01 -0.5000 3.416667e-01 0.5000 3.500000e-01 -0.5000 3.583333e-01 -0.5000 3.666667e-01 0.5000 3.750000e-01 -0.5000 3.833333e-01 0.5000 3.916667e-01 0.5000 4.000000e-01 -0.5000 4.083333e-01 0.5000 4.166667e-01 0.5000 4.250000e-01 0.5000 4.333333e-01 -0.5000 4.416667e-01 0.5000 4.500000e-01 -0.5000 4.583333e-01 0.5000 4.666667e-01 0.5000 4.750000e-01 0.5000 4.833333e-01 0.5000 4.916667e-01 0.5000 5.000000e-01 -0.5000 5.083333e-01 0.5000 5.166667e-01 -0.5000 5.250000e-01 -0.5000 5.333333e-01 -0.5000 5.416667e-01 -0.5000 5.500000e-01 0.5000 5.583333e-01 0.5000 5.666667e-01 -0.5000 5.750000e-01 0.5000 5.833333e-01 -0.5000 5.916667e-01 0.5000 6.000000e-01 -0.5000 6.083333e-01 -0.5000 6.166667e-01 0.5000 6.250000e-01 -0.5000 6.333333e-01 0.5000 6.416667e-01 -0.5000 6.500000e-01 0.5000 6.583333e-01 0.5000 6.666667e-01 -0.5000 6.750000e-01 -0.5000 6.833333e-01 0.5000 6.916667e-01 -0.5000 7.000000e-01 -0.5000 7.083333e-01 0.5000 7.166667e-01 -0.5000 7.250000e-01 0.5000 7.333333e-01 0.5000 7.416667e-01 -0.5000 7.500000e-01 -0.5000 7.583333e-01 0.5000 7.666667e-01 -0.5000 7.750000e-01 0.5000 7.833333e-01 -0.5000 7.916667e-01 0.5000 8.000000e-01 -0.5000 8.083333e-01 -0.5000 8.166667e-01 -0.5000 8.250000e-01 -0.5000)
Vpix_5_5 photo_5_5 0 PWL(0.000000e+00 0.0000 8.333333e-03 0.0000 1.666667e-02 -0.5000 2.500000e-02 -0.5000 3.333333e-02 -0.5000 4.166667e-02 -0.5000 5.000000e-02 0.5000 5.833333e-02 -0.5000 6.666667e-02 -0.5000 7.500000e-02 0.5000 8.333333e-02 -0.5000 9.166667e-02 0.5000 1.000000e-01 -0.5000 1.083333e-01 -0.5000 1.166667e-01 -0.5000 1.250000e-01 0.5000 1.333333e-01 0.5000 1.416667e-01 -0.5000 1.500000e-01 -0.5000 1.583333e-01 -0.5000 1.666667e-01 -0.5000 1.750000e-01 -0.5000 1.833333e-01 -0.5000 1.916667e-01 -0.5000 2.000000e-01 0.5000 2.083333e-01 -0.5000 2.166667e-01 -0.5000 2.250000e-01 -0.5000 2.333333e-01 0.5000 2.416667e-01 0.5000 2.500000e-01 -0.5000 2.583333e-01 0.5000 2.666667e-01 -0.5000 2.750000e-01 0.5000 2.833333e-01 -0.5000 2.916667e-01 0.5000 3.000000e-01 0.5000 3.083333e-01 -0.5000 3.166667e-01 0.5000 3.250000e-01 0.5000 3.333333e-01 -0.5000 3.416667e-01 0.5000 3.500000e-01 0.5000 3.583333e-01 0.5000 3.666667e-01 0.5000 3.750000e-01 -0.5000 3.833333e-01 0.5000 3.916667e-01 0.5000 4.000000e-01 -0.5000 4.083333e-01 0.5000 4.166667e-01 0.5000 4.250000e-01 -0.5000 4.333333e-01 0.5000 4.416667e-01 -0.5000 4.500000e-01 0.5000 4.583333e-01 0.5000 4.666667e-01 0.5000 4.750000e-01 -0.5000 4.833333e-01 -0.5000 4.916667e-01 0.5000 5.000000e-01 -0.5000 5.083333e-01 -0.5000 5.166667e-01 -0.5000 5.250000e-01 -0.5000 5.333333e-01 0.5000 5.416667e-01 0.5000 5.500000e-01 -0.5000 5.583333e-01 -0.5000 5.666667e-01 0.5000 5.750000e-01 0.5000 5.833333e-01 0.5000 5.916667e-01 0.5000 6.000000e-01 -0.5000 6.083333e-01 -0.5000 6.166667e-01 0.5000 6.250000e-01 0.5000 6.333333e-01 -0.5000 6.416667e-01 0.5000 6.500000e-01 0.5000 6.583333e-01 0.5000 6.666667e-01 0.5000 6.750000e-01 -0.5000 6.833333e-01 -0.5000 6.916667e-01 0.5000 7.000000e-01 -0.5000 7.083333e-01 -0.5000 7.166667e-01 -0.5000 7.250000e-01 0.5000 7.333333e-01 0.5000 7.416667e-01 -0.5000 7.500000e-01 -0.5000 7.583333e-01 -0.5000 7.666667e-01 0.5000 7.750000e-01 0.5000 7.833333e-01 0.5000 7.916667e-01 0.5000 8.000000e-01 0.5000 8.083333e-01 -0.5000 8.166667e-01 0.5000 8.250000e-01 0.5000)
Vpix_5_6 photo_5_6 0 PWL(0.000000e+00 0.0000 8.333333e-03 0.0000 1.666667e-02 0.5000 2.500000e-02 -0.5000 3.333333e-02 0.5000 4.166667e-02 0.5000 5.000000e-02 -0.5000 5.833333e-02 0.5000 6.666667e-02 -0.5000 7.500000e-02 0.5000 8.333333e-02 0.5000 9.166667e-02 0.5000 1.000000e-01 0.5000 1.083333e-01 -0.5000 1.166667e-01 0.5000 1.250000e-01 0.5000 1.333333e-01 0.5000 1.416667e-01 0.5000 1.500000e-01 0.5000 1.583333e-01 -0.5000 1.666667e-01 0.5000 1.750000e-01 0.5000 1.833333e-01 -0.5000 1.916667e-01 -0.5000 2.000000e-01 -0.5000 2.083333e-01 -0.5000 2.166667e-01 -0.5000 2.250000e-01 0.5000 2.333333e-01 -0.5000 2.416667e-01 -0.5000 2.500000e-01 -0.5000 2.583333e-01 -0.5000 2.666667e-01 -0.5000 2.750000e-01 -0.5000 2.833333e-01 0.5000 2.916667e-01 0.5000 3.000000e-01 0.5000 3.083333e-01 0.5000 3.166667e-01 0.5000 3.250000e-01 0.5000 3.333333e-01 0.5000 3.416667e-01 0.5000 3.500000e-01 -0.5000 3.583333e-01 -0.5000 3.666667e-01 0.5000 3.750000e-01 -0.5000 3.833333e-01 -0.5000 3.916667e-01 -0.5000 4.000000e-01 -0.5000 4.083333e-01 0.5000 4.166667e-01 0.5000 4.250000e-01 0.5000 4.333333e-01 0.5000 4.416667e-01 -0.5000 4.500000e-01 -0.5000 4.583333e-01 -0.5000 4.666667e-01 -0.5000 4.750000e-01 0.5000 4.833333e-01 -0.5000 4.916667e-01 0.5000 5.000000e-01 -0.5000 5.083333e-01 -0.5000 5.166667e-01 0.5000 5.250000e-01 -0.5000 5.333333e-01 -0.5000 5.416667e-01 -0.5000 5.500000e-01 -0.5000 5.583333e-01 -0.5000 5.666667e-01 -0.5000 5.750000e-01 -0.5000 5.833333e-01 -0.5000 5.916667e-01 0.5000 6.000000e-01 0.5000 6.083333e-01 0.5000 6.166667e-01 -0.5000 6.250000e-01 0.5000 6.333333e-01 -0.5000 6.416667e-01 -0.5000 6.500000e-01 0.5000 6.583333e-01 -0.5000 6.666667e-01 0.5000 6.750000e-01 0.5000 6.833333e-01 -0.5000 6.916667e-01 0.5000 7.000000e-01 0.5000 7.083333e-01 0.5000 7.166667e-01 -0.5000 7.250000e-01 -0.5000 7.333333e-01 0.5000 7.416667e-01 0.5000 7.500000e-01 -0.5000 7.583333e-01 0.5000 7.666667e-01 0.5000 7.750000e-01 0.5000 7.833333e-01 -0.5000 7.916667e-01 0.5000 8.000000e-01 0.5000 8.083333e-01 -0.5000 8.166667e-01 0.5000 8.250000e-01 -0.5000)
Vpix_5_7 photo_5_7 0 PWL(0.000000e+00 0.0000 8.333333e-03 0.0000 1.666667e-02 -0.5000 2.500000e-02 -0.5000 3.333333e-02 -0.5000 4.166667e-02 0.5000 5.000000e-02 0.5000 5.833333e-02 -0.5000 6.666667e-02 -0.5000 7.500000e-02 0.5000 8.333333e-02 -0.5000 9.166667e-02 0.5000 1.000000e-01 0.5000 1.083333e-01 0.5000 1.166667e-01 0.5000 1.250000e-01 -0.5000 1.333333e-01 -0.5000 1.416667e-01 0.5000 1.500000e-01 -0.5000 1.583333e-01 -0.5000 1.666667e-01 0.5000 1.750000e-01 -0.5000 1.833333e-01 -0.5000 1.916667e-01 0.5000 2.000000e-01 -0.5000 2.083333e-01 -0.5000 2.166667e-01 0.5000 2.250000e-01 -0.5000 2.333333e-01 -0.5000 2.416667e-01 0.5000 2.500000e-01 0.5000 2.583333e-01 0.5000 2.666667e-01 0.5000 2.750000e-01 -0.5000 2.833333e-01 0.5000 2.916667e-01 0.5000 3.000000e-01 0.5000 3.083333e-01 -0.5000 3.166667e-01 0.5000 3.250000e-01 0.5000 3.333333e-01 -0.5000 3.416667e-01 0.5000 3.500000e-01 0.5000 3.583333e-01 0.5000 3.666667e-01 0.5000 3.750000e-01 -0.5000 3.833333e-01 0.5000 3.916667e-01 0.5000 4.000000e-01 0.5000 4.083333e-01 -0.5000 4.166667e-01 0.5000 4.250000e-01 -0.5000 4.333333e-01 -0.5000 4.416667e-01 -0.5000 4.500000e-01 -0.5000 4.583333e-01 -0.5000 4.666667e-01 -0.5000 4.750000e-01 0.5000 4.833333e-01 -0.5000 4.916667e-01 0.5000 5.000000e-01 0.5000 5.083333e-01 -0.5000 5.166667e-01 -0.5000 5.250000e-01 0.5000 5.333333e-01 0.5000 5.416667e-01 0.5000 5.500000e-01 -0.5000 5.583333e-01 0.5000 5.666667e-01 0.5000 5.750000e-01 -0.5000 5.833333e-01 -0.5000 5.916667e-01 -0.5000 6.000000e-01 0.5000 6.083333e-01 -0.5000 6.166667e-01 0.5000 6.250000e-01 -0.5000 6.333333e-01 0.5000 6.416667e-01 0.5000 6.500000e-01 -0.5000 6.583333e-01 0.5000 6.666667e-01 0.5000 6.750000e-01 -0.5000 6.833333e-01 0.5000 6.916667e-01 0.5000 7.000000e-01 0.5000 7.083333e-01 -0.5000 7.166667e-01 -0.5000 7.250000e-01 0.5000 7.333333e-01 0.5000 7.416667e-01 0.5000 7.500000e-01 -0.5000 7.583333e-01 0.5000 7.666667e-01 0.5000 7.750000e-01 -0.5000 7.833333e-01 0.5000 7.916667e-01 -0.5000 8.000000e-01 -0.5000 8.083333e-01 0.5000 8.166667e-01 0.5000 8.250000e-01 0.5000)

* Horizontal-cell layer: each node couples to its own photoreceptor
* (R_IN) and to its up/down/left/right neighbors (R_LAT) -- this lateral
* coupling is what performs the spatial low-pass / surround averaging.
Rin_1_3 photo_1_3 horiz_1_3 10000
Rlat_1_3_r horiz_1_3 horiz_1_4 15000
Rlat_1_3_d horiz_1_3 horiz_2_3 15000
Rin_1_4 photo_1_4 horiz_1_4 10000
Rlat_1_4_r horiz_1_4 horiz_1_5 15000
Rlat_1_4_d horiz_1_4 horiz_2_4 15000
Rin_1_5 photo_1_5 horiz_1_5 10000
Rlat_1_5_r horiz_1_5 horiz_1_6 15000
Rlat_1_5_d horiz_1_5 horiz_2_5 15000
Rin_1_6 photo_1_6 horiz_1_6 10000
Rlat_1_6_r horiz_1_6 horiz_1_7 15000
Rlat_1_6_d horiz_1_6 horiz_2_6 15000
Rin_1_7 photo_1_7 horiz_1_7 10000
Rlat_1_7_d horiz_1_7 horiz_2_7 15000
Rin_2_3 photo_2_3 horiz_2_3 10000
Rlat_2_3_r horiz_2_3 horiz_2_4 15000
Rlat_2_3_d horiz_2_3 horiz_3_3 15000
Rin_2_4 photo_2_4 horiz_2_4 10000
Rlat_2_4_r horiz_2_4 horiz_2_5 15000
Rlat_2_4_d horiz_2_4 horiz_3_4 15000
Rin_2_5 photo_2_5 horiz_2_5 10000
Rlat_2_5_r horiz_2_5 horiz_2_6 15000
Rlat_2_5_d horiz_2_5 horiz_3_5 15000
Rin_2_6 photo_2_6 horiz_2_6 10000
Rlat_2_6_r horiz_2_6 horiz_2_7 15000
Rlat_2_6_d horiz_2_6 horiz_3_6 15000
Rin_2_7 photo_2_7 horiz_2_7 10000
Rlat_2_7_d horiz_2_7 horiz_3_7 15000
Rin_3_3 photo_3_3 horiz_3_3 10000
Rlat_3_3_r horiz_3_3 horiz_3_4 15000
Rlat_3_3_d horiz_3_3 horiz_4_3 15000
Rin_3_4 photo_3_4 horiz_3_4 10000
Rlat_3_4_r horiz_3_4 horiz_3_5 15000
Rlat_3_4_d horiz_3_4 horiz_4_4 15000
Rin_3_5 photo_3_5 horiz_3_5 10000
Rlat_3_5_r horiz_3_5 horiz_3_6 15000
Rlat_3_5_d horiz_3_5 horiz_4_5 15000
Rin_3_6 photo_3_6 horiz_3_6 10000
Rlat_3_6_r horiz_3_6 horiz_3_7 15000
Rlat_3_6_d horiz_3_6 horiz_4_6 15000
Rin_3_7 photo_3_7 horiz_3_7 10000
Rlat_3_7_d horiz_3_7 horiz_4_7 15000
Rin_4_3 photo_4_3 horiz_4_3 10000
Rlat_4_3_r horiz_4_3 horiz_4_4 15000
Rlat_4_3_d horiz_4_3 horiz_5_3 15000
Rin_4_4 photo_4_4 horiz_4_4 10000
Rlat_4_4_r horiz_4_4 horiz_4_5 15000
Rlat_4_4_d horiz_4_4 horiz_5_4 15000
Rin_4_5 photo_4_5 horiz_4_5 10000
Rlat_4_5_r horiz_4_5 horiz_4_6 15000
Rlat_4_5_d horiz_4_5 horiz_5_5 15000
Rin_4_6 photo_4_6 horiz_4_6 10000
Rlat_4_6_r horiz_4_6 horiz_4_7 15000
Rlat_4_6_d horiz_4_6 horiz_5_6 15000
Rin_4_7 photo_4_7 horiz_4_7 10000
Rlat_4_7_d horiz_4_7 horiz_5_7 15000
Rin_5_3 photo_5_3 horiz_5_3 10000
Rlat_5_3_r horiz_5_3 horiz_5_4 15000
Rin_5_4 photo_5_4 horiz_5_4 10000
Rlat_5_4_r horiz_5_4 horiz_5_5 15000
Rin_5_5 photo_5_5 horiz_5_5 10000
Rlat_5_5_r horiz_5_5 horiz_5_6 15000
Rin_5_6 photo_5_6 horiz_5_6 10000
Rlat_5_6_r horiz_5_6 horiz_5_7 15000
Rin_5_7 photo_5_7 horiz_5_7 10000

* Center-surround output at the target cell's real receptive-field
* location (row=3, col=5, from Phase 1's STA peak pixel).
Bcs centersurround 0 V=4*(V(photo_3_5)-V(horiz_3_5))

* Temporal dynamics: simple RC low-pass (bipolar-cell integration delay).
Rtau centersurround bipolar 30000
Ctau bipolar 0 1e-06

* Spike generation: leaky integrate-and-fire (comparator + reset switch,
* the standard SPICE trick for I&F neurons -- there's no built-in primitive).
Rmemin bipolar vmem 100000
Rleak vmem 0 2e+06
Cmem vmem 0 3e-07 IC=0
* A hard ternary comparator here (0 or 3.3V, instantaneously) was too
* numerically stiff for the solver to converge through -- it kept stalling at
* one timestep and never advancing (verified directly: 80 output rows, most
* with an IDENTICAL repeated timestamp, far short of the requested duration).
* A steep but smooth (differentiable) tanh sigmoid gives the same effective
* comparator behavior while staying solvable. Gain matters a lot here: an
* earlier version used gain 200, which is so steep that ngspice's local-
* truncation-error estimator collapsed the timestep near every threshold
* approach (measured directly: 525,632 internal steps for what should be
* ~80, a 15x slowdown). Gain 20 is still a sharp, effectively-binary
* comparator but stays numerically solvable.
Bspike spike 0 V=1.65*(1+tanh((V(vmem)-0.15)*20))
Sreset vmem 0 spike 0 SWRESET
* The switch's control node is the SPIKE signal (0..V_SPIKE), not vmem, so
* its Vt must be calibrated to that scale -- a real bug found here: an
* earlier version used Vt=V_THRESH/2 (0.075), a threshold meant for the
* ~0.1V-scale membrane voltage, on a signal that actually swings to 3.3V.
* That let the switch fire (and clamp vmem toward 0) the instant vmem got
* anywhere near threshold, long before the comparator actually went high --
* which is why vmem never rose past ~0.06V and no spikes were ever produced.
* Also softened Ron:Roff from 20,000:1 to 500:1 -- the original ratio was
* part of the same convergence problem.
.model SWRESET SW(Ron=200 Roff=100k Vt=1.65 Vh=0.66)

* Convergence aids for this stiff switched/nonlinear circuit -- reltol
* loosened from the 0.001 default (fine for this qualitative demo, not
* a precision analog design), gmin raised slightly, iteration limit raised.
.options reltol=0.01 gmin=1e-9 itl4=500

.tran 1.041667e-03 8.333333e-01 0 8.333333e-03 uic

.control
run
wrdata circuit_out.txt v(centersurround) v(bipolar) v(vmem) v(spike)
quit
.endc
.end
